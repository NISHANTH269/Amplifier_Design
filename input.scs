// Design: Second/CommonDrain
simulator lang=spectre
global 0 vdd!
parameters vg=600m vin=250m
include "/ECEnet/Apps1/linux/cad12/tools/PDKs/gpdk180_v3.3/models/spectre/gpdk.scs" section=stat

// Second/CommonDrain/schematic
V0 (In 0) vsource dc=vg mag=1 type=sine ampl=vin freq=100K
PM1 (Out net3 vdd! vdd!) pmos1 w=(1.25u) l=500n m=(1)*(8)
PM0 (0 In Out vdd!) pmos1 w=(4u) l=180n m=(1)*(8)
V2 (net3 0) vsource dc=1 type=dc
V1 (vdd! 0) vsource dc=1.8 type=dc
C0 (Out 0) capacitor c=200f
I10 (0 net015) isource mag=1 type=sine
simulatorOptions options temp=27
tran tran stop=50u errpreset=conservative
